* Reference schematic for 2x2 AB/BA NFET differential-pair input core

.subckt nfet_2x2_diffpair GATE_A GATE_B DRAIN_A DRAIN_B TAIL BULK

* Active matched devices
XA0 DRAIN_A GATE_A TAIL BULK nfet_03v3 w=3u l=0.28u
XA1 DRAIN_A GATE_A TAIL BULK nfet_03v3 w=3u l=0.28u
XB0 DRAIN_B GATE_B TAIL BULK nfet_03v3 w=3u l=0.28u
XB1 DRAIN_B GATE_B TAIL BULK nfet_03v3 w=3u l=0.28u

* Perimeter dummy devices tied to bulk
XDA0 BULK BULK BULK BULK nfet_03v3 w=3u l=0.28u
XDA1 BULK BULK BULK BULK nfet_03v3 w=3u l=0.28u
XDB0 BULK BULK BULK BULK nfet_03v3 w=3u l=0.28u
XDB1 BULK BULK BULK BULK nfet_03v3 w=3u l=0.28u

.ends nfet_2x2_diffpair
